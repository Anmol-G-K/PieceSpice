* Gate charge measurement - constant gate current
.include C:\Users\GNKRISHNAN\Documents\GitHub\PieceSpice\SpiceModels\ng_csd18510kcs.lib

Vds drain 0 DC 10.0
Ig gate 0 PULSE(0 1e-3 0 1u 1u 50u 100u)  ; 1mA gate current pulse
XM1 drain gate 0 csd18510kcs

.tran 0.1u 100u
.print tran V(gate) I(Ig)
.end
